ADE simulation setup
Run mode: Single Run, Sweeps and Corners
Tests:
  PSS (off): ELEN6320_FINALPROJECT/PowerMatching_VCO/schematic, simulator spectre
  HB: ELEN6320_FINALPROJECT/PowerMatching_VCO/schematic, simulator spectre
Global variables:
  numfin1 = 5
  mult = 8
  VGS = 0.7
  VG2 = 800m
  VG1 = 0.6
  VDS = 1.2
  VB = 800m
  Ldrain = 120p
  Lbuffer = 375p
  Cc = 15f
  Lgate = 50p
