ADE simulation setup
Run mode: Single Run, Sweeps and Corners
Tests:
  Jopt (off): ELEN6320_Receiver/ac_LNA_tb/schematic, simulator spectre
  Cascode_Ft: ELEN6320_Receiver/ac_LNA_tb/schematic, simulator spectre
  Rsopt (off): ELEN6320_Receiver/ac_LNA_tb/schematic, simulator spectre
  Ls: ELEN6320_Receiver/ac_LNA_tb/schematic, simulator spectre
  Lg: ELEN6320_Receiver/ac_LNA_tb/schematic, simulator spectre
  Ld1: ELEN6320_Receiver/ac_LNA_tb/schematic, simulator spectre
  COUT1: ELEN6320_Receiver/ac_LNA_tb/schematic, simulator spectre
  CMULT2: ELEN6320_Receiver/ac_LNA_tb/schematic, simulator spectre
  Verification: ELEN6320_Receiver/ac_LNA_tb/schematic, simulator spectre
Global variables:
  fingers1 = 35
  fingers2 = 35
  LG = 80.66p
  LM = 231.6p
  LS1 = 134.3p
  vbias = 0.522
  VPWR = 1.2
  COUT1 = 50f
  CMULT2 = 0.5
  LD = 109.7p
