ADE simulation setup
Run mode: Single Run, Sweeps and Corners
Tests:
  Cascode_Ft (off): ELEN6320_Receiver/ac_LNA_tb/schematic, simulator spectre
  Ls (off): ELEN6320_Receiver/ac_LNA_tb/schematic, simulator spectre
  Lg (off): ELEN6320_Receiver/ac_LNA_tb/schematic, simulator spectre
  Ld1 (off): ELEN6320_Receiver/ac_LNA_tb/schematic, simulator spectre
  Ld2 (off): ELEN6320_Receiver/ac_LNA_tb/schematic, simulator spectre
  COUT1 (off): ELEN6320_Receiver/ac_LNA_tb/schematic, simulator spectre
  CSERIES (off): ELEN6320_Receiver/ac_LNA_tb/schematic, simulator spectre
  CSHUNT (off): ELEN6320_Receiver/ac_LNA_tb/schematic, simulator spectre
  Optimize (off): ELEN6320_Receiver/ac_LNA_tb/schematic, simulator spectre
    Outputs: S22 dB20; S21 dB20
  Verification: ELEN6320_Receiver/ac_LNA_tb/schematic, simulator spectre
  Verification_50_70: ELEN6320_Receiver/ac_LNA_tb/schematic, simulator spectre
Global variables:
  LG = 72.82p
  LM = 231.6p
  LS1 = 113.0p
  COUT1 = 50f
  CSERIES = 12f
  CSHUNT = 7.4f
  LD1 = 109.7p
  LD2 = 109.7p
  prf = -40
Specs:
  Verification / S22 dB20: < -15
  Verification / S11 dB20: < -15
  Verification / NF dB10: < 6
  Verification / S21 dB20: range 18 to 26
  Verification / Input Referred 1dB Compression Point: > -30
  Verification / Power: < 24m
