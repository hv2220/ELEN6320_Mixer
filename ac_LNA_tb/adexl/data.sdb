ADE simulation setup
Run mode: Single Run, Sweeps and Corners
Tests:
  Jopt: RAB_IPL90nm_Project/ac_LNA_tb/schematic, simulator spectre
  Cascode_Ft: RAB_IPL90nm_Project/ac_LNA_tb/schematic, simulator spectre
  Rsopt: RAB_IPL90nm_Project/ac_LNA_tb/schematic, simulator spectre
  Ls: RAB_IPL90nm_Project/ac_LNA_tb/schematic, simulator spectre
  Lg: RAB_IPL90nm_Project/ac_LNA_tb/schematic, simulator spectre
  Verification: RAB_IPL90nm_Project/ac_LNA_tb/schematic, simulator spectre
Global variables:
  fingers1 = 35
  fingers2 = 35
  LD1 = 110p
  LD2 = 110p
  fw = 1u
  LG = 113p
  LM1 = 1n
  LM2 = 1n
  LS1 = 45p
  vbias = 0.522
  VPWR = 1.2
  COUT1 = 150f
  COUT2 = 65f
