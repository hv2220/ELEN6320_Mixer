ADE simulation setup
Run mode: Single Run, Sweeps and Corners
Tests:
  Jopt: ELEN6320_Receiver/ac_LNA_tb/schematic, simulator spectre
  Cascode_Ft: ELEN6320_Receiver/ac_LNA_tb/schematic, simulator spectre
  Rsopt: ELEN6320_Receiver/ac_LNA_tb/schematic, simulator spectre
  Ls: ELEN6320_Receiver/ac_LNA_tb/schematic, simulator spectre
  Lg: ELEN6320_Receiver/ac_LNA_tb/schematic, simulator spectre
  Ld1: ELEN6320_Receiver/ac_LNA_tb/schematic, simulator spectre
  Ld2: ELEN6320_Receiver/ac_LNA_tb/schematic, simulator spectre
  COUT1: ELEN6320_Receiver/ac_LNA_tb/schematic, simulator spectre
  CMULT2: ELEN6320_Receiver/ac_LNA_tb/schematic, simulator spectre
  Verification: ELEN6320_Receiver/ac_LNA_tb/schematic, simulator spectre
Global variables:
  fingers1 = 35
  fingers2 = 35
  LD1 = 110p
  LD2 = 110p
  LG = 110p
  LM1 = 1n
  LM2 = 1n
  LS1 = 45p
  vbias = 0.522
  VPWR = 1.2
  COUT1 = 150f
  COUT2 = 65f
  CMULT2 = 0.45
